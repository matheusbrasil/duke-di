* tone_eq.cir - Duke DI interactive FMV tone stack + treble-dependent low-cut.
*
* Node-for-node reproduction of the Noble/Nobelium passive tone network, as
* read from the schematic (files/sch/audio_full.png) and documented in
* docs/01-circuit-analysis.md. This is the SAME topology the DSP models with
* reference/python/tonestack.py (MNA solver); run it to cross-check the baked
* EQ curves against SPICE.
*
* Nodes:
*   P  = V1B plate (stack input), fed through PLATE_ZOUT = 7.4k source Z
*   M  = R13 bottom / C10 left / C11 left (mid node)
*   A  = C10 right / TREBLE bottom / BASS top
*   B  = C11 right / R21 top / BASS bottom
*   T  = TREBLE wiper = stack OUTPUT
*   Tt = TREBLE top / C6 right (treble bleed)
*
* Pots are A250k. wt/wb are WIPER FRACTIONS (already taper-mapped: noon ~0.15).
*   TREBLE wiper: Rtop(Tt-T) = (1-wt)*250k, Rbot(T-A) = wt*250k; wt=1 -> bright.
*   BASS is a rheostat A-B of value wb*250k.
* EPS = 1 ohm guards the pot ends against exact 0 ohm.
*
* Run:   ngspice -b tone_eq.cir   -> writes ../validation/spice_tone_ac.txt
* Sweep wt, wb in 0..1 (noon ~0.15) and lowcut in {0,1} to explore.

.param wt=0.15 wb=0.15 lowcut=1
.param EPS=1
.param RT_TOP={(1-wt)*250k + EPS}
.param RT_BOT={wt*250k + EPS}
.param RBASS={wb*250k + EPS}

Vin  in 0 AC 1 DC 0

* ---- plate output impedance (rp 12AU7 ~7.7k || R9 220k) -------------------
Rsrc in P 7.4k

* ---- FMV tone stack ------------------------------------------------------
R13  P  M   47k
C6   P  Tt  270p
C10  M  A   100n
C11  M  B   100n
* TREBLE A250k: top=Tt, wiper=T (output), bottom=A
RTt  Tt T   {RT_TOP}
RTb  T  A   {RT_BOT}
* BASS A250k rheostat A-B
RB   A  B   {RBASS}
R21  B  0   2k7
* grid-side load on the wiper (TONE_LOAD ~ 1M)
Rload T 0   1Meg

* ---- ROLLOFF low-cut: C8 4n7 fed from the wiper into R18 220k -------------
* fc = 1/(2*pi*(Zout(T)+220k)*4n7); switch shorts the cap when off.
C8   T  nlc  4.7n
R18  nlc 0   220k
* lowcut=0 -> bypass C8 with a near-short; lowcut=1 -> cap in circuit (huge R)
Rbyp T  nlc  {1e12*lowcut + 1e-3*(1-lowcut)}

.control
  ac dec 50 10 100k
  wrdata ../validation/spice_tone_ac.txt vdb(T)
.endc
.end
